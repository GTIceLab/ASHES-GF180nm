* Clock path of each charge pump, as placed in chip_top.
*
* pad -> inv_1 -> inv_4 -> NonOvCLKGen (NOR latch, inv_4 and inv_20 output drivers) -> PHI1, PHI2
*
* The NOR latch is copied from 1_Design/GF180_cells/NonOvCLKGen/design/NonOvCLKGen.sch.
* The inv_4 and inv_20 output drivers are copied from
* 1_Design/GF180_cells/TunnelingChargePump/TunnelingChargePump_TB.sch and match the
* standard cells found inside the NonOvCLKGen layout cell.

.subckt NonOvCLKGen_core CLK_IN PHI1 PHI2 VDD GND
XINV_BAR CLK_IN CLK_IN_BAR VDD VDD GND GND gf180mcu_fd_sc_mcu7t5v0__clkinv_1
XNOR1 PHI2 CLK_IN_BAR NOR1_OUT VDD VDD GND GND gf180mcu_fd_sc_mcu7t5v0__nor2_1
XNOR2 PHI1 CLK_IN NOR2_OUT VDD VDD GND GND gf180mcu_fd_sc_mcu7t5v0__nor2_1
XBUF1 NOR1_OUT BUF1_OUT VDD VDD GND GND gf180mcu_fd_sc_mcu7t5v0__clkbuf_2
XBUF2 BUF1_OUT PHI1 VDD VDD GND GND gf180mcu_fd_sc_mcu7t5v0__clkbuf_2
XBUF3 NOR2_OUT BUF3_OUT VDD VDD GND GND gf180mcu_fd_sc_mcu7t5v0__clkbuf_2
XBUF4 BUF3_OUT PHI2 VDD VDD GND GND gf180mcu_fd_sc_mcu7t5v0__clkbuf_2
.ends

.subckt NonOvCLKGen CLK_IN PHI1_out PHI2_out VDD GND
XCORE CLK_IN PHI1 PHI2 VDD GND NonOvCLKGen_core
XINV1 PHI1 PHI1_1 VDD VDD GND GND gf180mcu_fd_sc_mcu7t5v0__inv_4
XINV2 PHI1_1 PHI1_out VDD VDD GND GND gf180mcu_fd_sc_mcu7t5v0__inv_20
XINV3 PHI2 PHI2_1 VDD VDD GND GND gf180mcu_fd_sc_mcu7t5v0__inv_4
XINV4 PHI2_1 PHI2_out VDD VDD GND GND gf180mcu_fd_sc_mcu7t5v0__inv_20
.ends

* Pad buffer in front of each clock generator in chip_top.
.subckt pump_clock PAD PHI1_out PHI2_out VDD GND
XB1 PAD N1 VDD VDD GND GND gf180mcu_fd_sc_mcu7t5v0__inv_1
XB2 N1 CLK_IN VDD VDD GND GND gf180mcu_fd_sc_mcu7t5v0__inv_4
XGEN CLK_IN PHI1_out PHI2_out VDD GND NonOvCLKGen
.ends
