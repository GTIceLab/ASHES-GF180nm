* Extracted by KLayout with GF180MCU LVS runset on : 05/10/2026 16:12

* cell 3NFET
.SUBCKT 3NFET
* cell instance $1 r0 *1 -2.72,-3.91
X$1 Vs Vd_Small Vg gf180mcu_gnd nfet
* cell instance $2 r0 *1 0,-3.91
X$2 Vd_Med Vs Vg gf180mcu_gnd nfet$6
* cell instance $3 r0 *1 3.57,-3.91
X$3 Vs Vd_Large Vs Vd_Large Vs Vd_Large Vs Vd_Large Vs Vd_Large Vs Vg Vg Vg Vg
+ Vg Vg Vg Vg Vg Vg gf180mcu_gnd nfet$1
.ENDS 3NFET

* cell nfet$1
* pin
* pin
* pin
* pin
* pin
* pin
* pin
* pin
* pin
* pin
* pin
* pin
* pin
* pin
* pin
* pin
* pin
* pin
* pin
* pin
* pin
* pin gf180mcu_gnd
.SUBCKT nfet$1 \$1 \$2 \$3 \$4 \$5 \$6 \$7 \$8 \$9 \$10 \$11 \$12 \$13 \$14
+ \$15 \$16 \$17 \$18 \$19 \$20 \$22 gf180mcu_gnd
* device instance $1 r0 *1 0.58,2.5 nfet_03v3
M$1 \$2 \$12 \$1 gf180mcu_gnd nfet_03v3 L=0.28U W=5U AS=2.2P AD=1.3P PS=10.88U
+ PD=5.52U
* device instance $2 r0 *1 1.38,2.5 nfet_03v3
M$2 \$3 \$13 \$2 gf180mcu_gnd nfet_03v3 L=0.28U W=5U AS=1.3P AD=1.3P PS=5.52U
+ PD=5.52U
* device instance $3 r0 *1 2.18,2.5 nfet_03v3
M$3 \$4 \$14 \$3 gf180mcu_gnd nfet_03v3 L=0.28U W=5U AS=1.3P AD=1.3P PS=5.52U
+ PD=5.52U
* device instance $4 r0 *1 2.98,2.5 nfet_03v3
M$4 \$5 \$15 \$4 gf180mcu_gnd nfet_03v3 L=0.28U W=5U AS=1.3P AD=1.3P PS=5.52U
+ PD=5.52U
* device instance $5 r0 *1 3.78,2.5 nfet_03v3
M$5 \$6 \$16 \$5 gf180mcu_gnd nfet_03v3 L=0.28U W=5U AS=1.3P AD=1.3P PS=5.52U
+ PD=5.52U
* device instance $6 r0 *1 4.58,2.5 nfet_03v3
M$6 \$7 \$17 \$6 gf180mcu_gnd nfet_03v3 L=0.28U W=5U AS=1.3P AD=1.3P PS=5.52U
+ PD=5.52U
* device instance $7 r0 *1 5.38,2.5 nfet_03v3
M$7 \$8 \$18 \$7 gf180mcu_gnd nfet_03v3 L=0.28U W=5U AS=1.3P AD=1.3P PS=5.52U
+ PD=5.52U
* device instance $8 r0 *1 6.18,2.5 nfet_03v3
M$8 \$9 \$19 \$8 gf180mcu_gnd nfet_03v3 L=0.28U W=5U AS=1.3P AD=1.3P PS=5.52U
+ PD=5.52U
* device instance $9 r0 *1 6.98,2.5 nfet_03v3
M$9 \$10 \$20 \$9 gf180mcu_gnd nfet_03v3 L=0.28U W=5U AS=1.3P AD=1.3P PS=5.52U
+ PD=5.52U
* device instance $10 r0 *1 7.78,2.5 nfet_03v3
M$10 \$11 \$22 \$10 gf180mcu_gnd nfet_03v3 L=0.28U W=5U AS=1.3P AD=2.2P
+ PS=5.52U PD=10.88U
.ENDS nfet$1

* cell nfet$6
* pin
* pin
* pin
* pin gf180mcu_gnd
.SUBCKT nfet$6 \$1 \$2 \$4 gf180mcu_gnd
* device instance $1 r0 *1 0.58,2.5 nfet_03v3
M$1 \$2 \$4 \$1 gf180mcu_gnd nfet_03v3 L=0.28U W=5U AS=2.2P AD=2.2P PS=10.88U
+ PD=10.88U
.ENDS nfet$6

* cell nfet
* pin
* pin
* pin
* pin gf180mcu_gnd
.SUBCKT nfet \$1 \$2 \$4 gf180mcu_gnd
* device instance $1 r0 *1 0.58,0.25 nfet_03v3
M$1 \$2 \$4 \$1 gf180mcu_gnd nfet_03v3 L=0.28U W=0.5U AS=0.22P AD=0.22P
+ PS=1.88U PD=1.88U
.ENDS nfet
