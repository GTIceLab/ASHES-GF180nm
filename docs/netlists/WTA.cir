* Extracted by KLayout with GF180MCU LVS runset on : 05/10/2026 16:12

* cell WTA
.SUBCKT WTA
* cell instance $1 r270 *1 12.36,1.44
X$1 GND Vin<3> GND \$I5 \$6 gf180mcu_gnd nfet
* cell instance $2 r270 *1 17.91,1.44
X$2 \$6 Bias<3> GND \$I11 Vin<3> gf180mcu_gnd nfet$2
* cell instance $3 r270 *1 4.93,1.44
X$3 \$5 Bias<2> GND \$I12 Vin<2> gf180mcu_gnd nfet$2
* cell instance $4 r270 *1 -0.62,1.44
X$4 GND Vin<2> GND \$I4 \$5 gf180mcu_gnd nfet
* cell instance $5 r0 *1 24.05,1.27
X$5 GND Vmid Vbias gf180mcu_gnd nfet$5
* cell instance $6 r90 *1 2.63,2.6
X$6 GND Vin<1> GND \$I4 \$9 gf180mcu_gnd nfet
* cell instance $7 r90 *1 15.61,2.6
X$7 GND Vin<0> GND \$I5 \$11 gf180mcu_gnd nfet
* cell instance $8 r90 *1 9.93,2.6
X$8 \$9 Bias<1> GND \$I12 Vin<1> gf180mcu_gnd nfet$2
* cell instance $9 r90 *1 22.91,2.6
X$9 \$11 Bias<0> GND \$I11 Vin<0> gf180mcu_gnd nfet$2
.ENDS WTA

* cell nfet$5
* pin
* pin
* pin
* pin gf180mcu_gnd
.SUBCKT nfet$5 \$1 \$2 \$4 gf180mcu_gnd
* device instance $1 r0 *1 0.94,0.75 nfet_06v0
M$1 \$2 \$4 \$1 gf180mcu_gnd nfet_06v0 L=1U W=1.5U AS=0.66P AD=0.66P PS=3.88U
+ PD=3.88U
.ENDS nfet$5

* cell nfet$2
* pin
* pin
* pin
* pin
* pin
* pin gf180mcu_gnd
.SUBCKT nfet$2 \$1 \$2 \$3 \$5 \$6 gf180mcu_gnd
* device instance $1 r0 *1 1.19,2.5 nfet_06v0
M$1 \$2 \$6 \$1 gf180mcu_gnd nfet_06v0 L=1.5U W=5U AS=2.2P AD=2.2P PS=10.88U
+ PD=10.88U
.ENDS nfet$2

* cell nfet
* pin
* pin
* pin
* pin
* pin
* pin gf180mcu_gnd
.SUBCKT nfet \$1 \$2 \$3 \$5 \$6 gf180mcu_gnd
* device instance $1 r0 *1 1.44,1.625 nfet_06v0
M$1 \$2 \$6 \$1 gf180mcu_gnd nfet_06v0 L=2U W=3.25U AS=1.43P AD=1.43P PS=7.38U
+ PD=7.38U
.ENDS nfet
