* Extracted by KLayout with GF180MCU LVS runset on : 10/07/2026 14:46

.SUBCKT NonOvCLKGen
X$1 GND VDD CLK_IN PHI1 \$8 VDD GND GND gf180mcu_fd_sc_mcu7t5v0__nor2_1
X$2 GND VDD CLK_IN \$15 VDD GND GND gf180mcu_fd_sc_mcu7t5v0__clkinv_1
X$3 VDD GND gf180mcu_fd_sc_mcu7t5v0__filltie
X$4 \$8 VDD GND \$9 VDD GND GND gf180mcu_fd_sc_mcu7t5v0__clkbuf_2
X$5 \$9 VDD GND PHI2 VDD GND GND gf180mcu_fd_sc_mcu7t5v0__clkbuf_2
X$6 \$6 VDD GND \$7 VDD GND GND gf180mcu_fd_sc_mcu7t5v0__clkbuf_2
X$7 \$7 VDD GND PHI1 VDD GND GND gf180mcu_fd_sc_mcu7t5v0__clkbuf_2
X$8 GND VDD \$15 PHI2 \$6 VDD GND GND gf180mcu_fd_sc_mcu7t5v0__nor2_1
X$9 VDD GND gf180mcu_fd_sc_mcu7t5v0__filltie
.ENDS NonOvCLKGen

.SUBCKT gf180mcu_fd_sc_mcu7t5v0__clkbuf_2 I VDD VSS Z \$6 \$7 SUB
M$1 \$4 I VDD \$6 pfet_05v0 L=0.5U W=1.02U AS=0.458P AD=0.4488P PS=2.02U
+ PD=2.92U
M$2 Z \$4 VDD \$6 pfet_05v0 L=0.5U W=1.22U AS=0.458P AD=0.3782P PS=2.02U
+ PD=1.84U
M$3 VDD \$4 Z \$6 pfet_05v0 L=0.5U W=1.22U AS=0.3782P AD=0.5368P PS=1.84U
+ PD=3.32U
M$4 \$4 I VSS SUB nfet_05v0 L=0.6U W=0.36U AS=0.151P AD=0.1584P PS=1.185U
+ PD=1.6U
M$5 Z \$4 VSS SUB nfet_05v0 L=0.6U W=0.485U AS=0.151P AD=0.1261P PS=1.185U
+ PD=1.005U
M$6 VSS \$4 Z SUB nfet_05v0 L=0.6U W=0.485U AS=0.1261P AD=0.2134P PS=1.005U
+ PD=1.85U
.ENDS gf180mcu_fd_sc_mcu7t5v0__clkbuf_2

.SUBCKT gf180mcu_fd_sc_mcu7t5v0__clkinv_1 VSS VDD I ZN \$5 \$6 SUB
M$1 ZN I VDD \$5 pfet_05v0 L=0.5U W=1.22U AS=0.5368P AD=0.5368P PS=3.32U
+ PD=3.32U
M$2 ZN I VSS SUB nfet_05v0 L=0.6U W=0.48U AS=0.2112P AD=0.2112P PS=1.84U
+ PD=1.84U
.ENDS gf180mcu_fd_sc_mcu7t5v0__clkinv_1

.SUBCKT gf180mcu_fd_sc_mcu7t5v0__filltie VDD VSS
.ENDS gf180mcu_fd_sc_mcu7t5v0__filltie

.SUBCKT gf180mcu_fd_sc_mcu7t5v0__nor2_1 VSS VDD A2 A1 ZN \$7 \$8 SUB
M$1 \$6 A2 VDD \$7 pfet_05v0 L=0.5U W=1.22U AS=0.5368P AD=0.4087P PS=3.32U
+ PD=1.89U
M$2 ZN A1 \$6 \$7 pfet_05v0 L=0.5U W=1.22U AS=0.4087P AD=0.5368P PS=1.89U
+ PD=3.32U
M$3 ZN A2 VSS SUB nfet_05v0 L=0.6U W=0.565U AS=0.2486P AD=0.1469P PS=2.01U
+ PD=1.085U
M$4 VSS A1 ZN SUB nfet_05v0 L=0.6U W=0.565U AS=0.1469P AD=0.2486P PS=1.085U
+ PD=2.01U
.ENDS gf180mcu_fd_sc_mcu7t5v0__nor2_1
