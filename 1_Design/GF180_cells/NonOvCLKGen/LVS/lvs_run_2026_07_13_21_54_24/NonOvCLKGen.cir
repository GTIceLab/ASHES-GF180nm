* Extracted by KLayout with GF180MCU LVS runset on : 13/07/2026 17:54

.SUBCKT NonOvCLKGen
X$1 GND \$6 PHI2_out GND VDD VDD GND gf180mcu_fd_sc_mcu7t5v0__inv_20
X$2 GND VDD \$8 \$6 VDD GND GND gf180mcu_fd_sc_mcu7t5v0__inv_4
X$3 VDD GND gf180mcu_fd_sc_mcu7t5v0__filltie
X$4 \$15 VDD GND \$11 VDD GND GND gf180mcu_fd_sc_mcu7t5v0__clkbuf_2
X$5 GND VDD \$17 \$8 \$15 VDD GND GND gf180mcu_fd_sc_mcu7t5v0__nor2_1
X$6 GND VDD CLK_IN \$17 VDD GND GND gf180mcu_fd_sc_mcu7t5v0__clkinv_1
X$7 GND VDD CLK_IN \$4 \$3 VDD GND GND gf180mcu_fd_sc_mcu7t5v0__nor2_1
X$8 \$5 VDD GND \$8 VDD GND GND gf180mcu_fd_sc_mcu7t5v0__clkbuf_2
X$9 \$3 VDD GND \$5 VDD GND GND gf180mcu_fd_sc_mcu7t5v0__clkbuf_2
X$10 \$11 VDD GND \$4 VDD GND GND gf180mcu_fd_sc_mcu7t5v0__clkbuf_2
X$11 GND VDD \$4 \$13 VDD GND GND gf180mcu_fd_sc_mcu7t5v0__inv_4
X$12 GND \$13 PHI1_out GND VDD VDD GND gf180mcu_fd_sc_mcu7t5v0__inv_20
X$13 VDD GND gf180mcu_fd_sc_mcu7t5v0__filltie
.ENDS NonOvCLKGen

.SUBCKT gf180mcu_fd_sc_mcu7t5v0__inv_20 VSS I ZN \$4 VDD \$6 SUB
M$1 ZN I VDD \$6 pfet_05v0 L=0.5U W=1.22U AS=0.5368P AD=0.3782P PS=3.32U
+ PD=1.84U
M$2 VDD I ZN \$6 pfet_05v0 L=0.5U W=1.22U AS=0.3782P AD=0.3782P PS=1.84U
+ PD=1.84U
M$3 ZN I VDD \$6 pfet_05v0 L=0.5U W=1.22U AS=0.3782P AD=0.3782P PS=1.84U
+ PD=1.84U
M$4 VDD I ZN \$6 pfet_05v0 L=0.5U W=1.22U AS=0.3782P AD=0.3782P PS=1.84U
+ PD=1.84U
M$5 ZN I VDD \$6 pfet_05v0 L=0.5U W=1.22U AS=0.3782P AD=0.3782P PS=1.84U
+ PD=1.84U
M$6 VDD I ZN \$6 pfet_05v0 L=0.5U W=1.22U AS=0.3782P AD=0.3782P PS=1.84U
+ PD=1.84U
M$7 ZN I VDD \$6 pfet_05v0 L=0.5U W=1.22U AS=0.3782P AD=0.3782P PS=1.84U
+ PD=1.84U
M$8 VDD I ZN \$6 pfet_05v0 L=0.5U W=1.22U AS=0.3782P AD=0.3782P PS=1.84U
+ PD=1.84U
M$9 ZN I VDD \$6 pfet_05v0 L=0.5U W=1.22U AS=0.3782P AD=0.3782P PS=1.84U
+ PD=1.84U
M$10 VDD I ZN \$6 pfet_05v0 L=0.5U W=1.22U AS=0.3782P AD=0.3782P PS=1.84U
+ PD=1.84U
M$11 ZN I VDD \$6 pfet_05v0 L=0.5U W=1.22U AS=0.3782P AD=0.3782P PS=1.84U
+ PD=1.84U
M$12 VDD I ZN \$6 pfet_05v0 L=0.5U W=1.22U AS=0.3782P AD=0.3782P PS=1.84U
+ PD=1.84U
M$13 ZN I VDD \$6 pfet_05v0 L=0.5U W=1.22U AS=0.3782P AD=0.3782P PS=1.84U
+ PD=1.84U
M$14 VDD I ZN \$6 pfet_05v0 L=0.5U W=1.22U AS=0.3782P AD=0.3782P PS=1.84U
+ PD=1.84U
M$15 ZN I VDD \$6 pfet_05v0 L=0.5U W=1.22U AS=0.3782P AD=0.3782P PS=1.84U
+ PD=1.84U
M$16 VDD I ZN \$6 pfet_05v0 L=0.5U W=1.22U AS=0.3782P AD=0.3782P PS=1.84U
+ PD=1.84U
M$17 ZN I VDD \$6 pfet_05v0 L=0.5U W=1.22U AS=0.3782P AD=0.3782P PS=1.84U
+ PD=1.84U
M$18 VDD I ZN \$6 pfet_05v0 L=0.5U W=1.22U AS=0.3782P AD=0.3782P PS=1.84U
+ PD=1.84U
M$19 ZN I VDD \$6 pfet_05v0 L=0.5U W=1.22U AS=0.3782P AD=0.3782P PS=1.84U
+ PD=1.84U
M$20 VDD I ZN \$6 pfet_05v0 L=0.5U W=1.22U AS=0.3782P AD=0.5368P PS=1.84U
+ PD=3.32U
M$21 ZN I VSS SUB nfet_05v0 L=0.6U W=0.82U AS=0.3608P AD=0.2132P PS=2.52U
+ PD=1.34U
M$22 VSS I ZN SUB nfet_05v0 L=0.6U W=0.82U AS=0.2132P AD=0.2132P PS=1.34U
+ PD=1.34U
M$23 ZN I VSS SUB nfet_05v0 L=0.6U W=0.82U AS=0.2132P AD=0.2132P PS=1.34U
+ PD=1.34U
M$24 VSS I ZN SUB nfet_05v0 L=0.6U W=0.82U AS=0.2132P AD=0.2132P PS=1.34U
+ PD=1.34U
M$25 ZN I VSS SUB nfet_05v0 L=0.6U W=0.82U AS=0.2132P AD=0.2132P PS=1.34U
+ PD=1.34U
M$26 VSS I ZN SUB nfet_05v0 L=0.6U W=0.82U AS=0.2132P AD=0.2132P PS=1.34U
+ PD=1.34U
M$27 ZN I VSS SUB nfet_05v0 L=0.6U W=0.82U AS=0.2132P AD=0.2132P PS=1.34U
+ PD=1.34U
M$28 VSS I ZN SUB nfet_05v0 L=0.6U W=0.82U AS=0.2132P AD=0.2132P PS=1.34U
+ PD=1.34U
M$29 ZN I VSS SUB nfet_05v0 L=0.6U W=0.82U AS=0.2132P AD=0.2132P PS=1.34U
+ PD=1.34U
M$30 VSS I ZN SUB nfet_05v0 L=0.6U W=0.82U AS=0.2132P AD=0.2132P PS=1.34U
+ PD=1.34U
M$31 ZN I VSS SUB nfet_05v0 L=0.6U W=0.82U AS=0.2132P AD=0.2132P PS=1.34U
+ PD=1.34U
M$32 VSS I ZN SUB nfet_05v0 L=0.6U W=0.82U AS=0.2132P AD=0.2132P PS=1.34U
+ PD=1.34U
M$33 ZN I VSS SUB nfet_05v0 L=0.6U W=0.82U AS=0.2132P AD=0.2132P PS=1.34U
+ PD=1.34U
M$34 VSS I ZN SUB nfet_05v0 L=0.6U W=0.82U AS=0.2132P AD=0.2132P PS=1.34U
+ PD=1.34U
M$35 ZN I VSS SUB nfet_05v0 L=0.6U W=0.82U AS=0.2132P AD=0.2132P PS=1.34U
+ PD=1.34U
M$36 VSS I ZN SUB nfet_05v0 L=0.6U W=0.82U AS=0.2132P AD=0.2132P PS=1.34U
+ PD=1.34U
M$37 ZN I VSS SUB nfet_05v0 L=0.6U W=0.82U AS=0.2132P AD=0.2132P PS=1.34U
+ PD=1.34U
M$38 VSS I ZN SUB nfet_05v0 L=0.6U W=0.82U AS=0.2132P AD=0.2132P PS=1.34U
+ PD=1.34U
M$39 ZN I VSS SUB nfet_05v0 L=0.6U W=0.82U AS=0.2132P AD=0.2132P PS=1.34U
+ PD=1.34U
M$40 VSS I ZN SUB nfet_05v0 L=0.6U W=0.82U AS=0.2132P AD=0.3608P PS=1.34U
+ PD=2.52U
.ENDS gf180mcu_fd_sc_mcu7t5v0__inv_20

.SUBCKT gf180mcu_fd_sc_mcu7t5v0__inv_4 VSS VDD I ZN \$5 \$6 SUB
M$1 ZN I VDD \$5 pfet_05v0 L=0.5U W=1.22U AS=0.5368P AD=0.4392P PS=3.32U
+ PD=1.94U
M$2 VDD I ZN \$5 pfet_05v0 L=0.5U W=1.22U AS=0.4392P AD=0.3172P PS=1.94U
+ PD=1.74U
M$3 ZN I VDD \$5 pfet_05v0 L=0.5U W=1.22U AS=0.3172P AD=0.4392P PS=1.74U
+ PD=1.94U
M$4 VDD I ZN \$5 pfet_05v0 L=0.5U W=1.22U AS=0.4392P AD=0.5368P PS=1.94U
+ PD=3.32U
M$5 ZN I VSS SUB nfet_05v0 L=0.6U W=0.82U AS=0.3608P AD=0.2132P PS=2.52U
+ PD=1.34U
M$6 VSS I ZN SUB nfet_05v0 L=0.6U W=0.82U AS=0.2132P AD=0.2132P PS=1.34U
+ PD=1.34U
M$7 ZN I VSS SUB nfet_05v0 L=0.6U W=0.82U AS=0.2132P AD=0.2132P PS=1.34U
+ PD=1.34U
M$8 VSS I ZN SUB nfet_05v0 L=0.6U W=0.82U AS=0.2132P AD=0.3608P PS=1.34U
+ PD=2.52U
.ENDS gf180mcu_fd_sc_mcu7t5v0__inv_4

.SUBCKT gf180mcu_fd_sc_mcu7t5v0__filltie VDD VSS
.ENDS gf180mcu_fd_sc_mcu7t5v0__filltie

.SUBCKT gf180mcu_fd_sc_mcu7t5v0__nor2_1 VSS VDD A2 A1 ZN \$7 \$8 SUB
M$1 \$6 A2 VDD \$7 pfet_05v0 L=0.5U W=1.22U AS=0.5368P AD=0.4087P PS=3.32U
+ PD=1.89U
M$2 ZN A1 \$6 \$7 pfet_05v0 L=0.5U W=1.22U AS=0.4087P AD=0.5368P PS=1.89U
+ PD=3.32U
M$3 ZN A2 VSS SUB nfet_05v0 L=0.6U W=0.565U AS=0.2486P AD=0.1469P PS=2.01U
+ PD=1.085U
M$4 VSS A1 ZN SUB nfet_05v0 L=0.6U W=0.565U AS=0.1469P AD=0.2486P PS=1.085U
+ PD=2.01U
.ENDS gf180mcu_fd_sc_mcu7t5v0__nor2_1

.SUBCKT gf180mcu_fd_sc_mcu7t5v0__clkinv_1 VSS VDD I ZN \$5 \$6 SUB
M$1 ZN I VDD \$5 pfet_05v0 L=0.5U W=1.22U AS=0.5368P AD=0.5368P PS=3.32U
+ PD=3.32U
M$2 ZN I VSS SUB nfet_05v0 L=0.6U W=0.48U AS=0.2112P AD=0.2112P PS=1.84U
+ PD=1.84U
.ENDS gf180mcu_fd_sc_mcu7t5v0__clkinv_1

.SUBCKT gf180mcu_fd_sc_mcu7t5v0__clkbuf_2 I VDD VSS Z \$6 \$7 SUB
M$1 \$4 I VDD \$6 pfet_05v0 L=0.5U W=1.02U AS=0.458P AD=0.4488P PS=2.02U
+ PD=2.92U
M$2 Z \$4 VDD \$6 pfet_05v0 L=0.5U W=1.22U AS=0.458P AD=0.3782P PS=2.02U
+ PD=1.84U
M$3 VDD \$4 Z \$6 pfet_05v0 L=0.5U W=1.22U AS=0.3782P AD=0.5368P PS=1.84U
+ PD=3.32U
M$4 \$4 I VSS SUB nfet_05v0 L=0.6U W=0.36U AS=0.151P AD=0.1584P PS=1.185U
+ PD=1.6U
M$5 Z \$4 VSS SUB nfet_05v0 L=0.6U W=0.485U AS=0.151P AD=0.1261P PS=1.185U
+ PD=1.005U
M$6 VSS \$4 Z SUB nfet_05v0 L=0.6U W=0.485U AS=0.1261P AD=0.2134P PS=1.005U
+ PD=1.85U
.ENDS gf180mcu_fd_sc_mcu7t5v0__clkbuf_2
