* Extracted by KLayout with GF180MCU LVS runset on : 14/07/2026 11:24

.SUBCKT InjectionSchottkyPump
C$1 Stage1_out PHI1_w 3.2e-12 cap_mim_2f0fF A=1600P P=160U
C$2 Stage2_out PHI2_w 3.2e-12 cap_mim_2f0fF A=1600P P=160U
C$3 Vout_e GND_w 3.2e-12 cap_mim_2f0fF A=1600P P=160U
.ENDS InjectionSchottkyPump
